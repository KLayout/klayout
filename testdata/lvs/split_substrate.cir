* Extracted by KLayout

.SUBCKT TOP A Q IOSUB SUBSTRATE
X$1 \$7 \$1 Q IOSUB IOSUB INV
X$2 \$7 A \$1 SUBSTRATE SUBSTRATE INV
.ENDS TOP

.SUBCKT INV \$2 \$4 \$5 \$1 \$I11
M$1 \$2 \$4 \$5 \$2 PMOS L=0.25U W=0.95U AS=0.73625P AD=0.73625P PS=3.45U
+ PD=3.45U
M$2 \$1 \$4 \$5 \$I11 NMOS L=0.25U W=0.95U AS=0.73625P AD=0.73625P PS=3.45U
+ PD=3.45U
.ENDS INV
